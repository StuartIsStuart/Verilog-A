`include "disciplines.vams"

module R(a, b);
  inout a, b;
  electrical a, b;
  parameter real R = 5000;
  analog begin
    I(a,b) <+ (V(a,b))/R;
  end
endmodule
