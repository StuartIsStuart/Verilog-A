`include "disciplines.vams"
`include "constants.vams"
module R(a, b);
  inout a, b;
  electrical a, b;
  parameter real R = 5000;
  analog begin
    V(a,b) <+ (I(a,b))*R;
  end
endmodule
