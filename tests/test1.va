`include "disciplines.vams"
`include "constants.vams"
module R(a, b);
  inout a, b;
  electrical a, b;
  parameter real C = 1e-7;
  analog begin
    I(a,b) <+(ddt(V(a,b)))*C;
  end
endmodule
