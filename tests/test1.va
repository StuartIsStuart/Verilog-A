`include "disciplines.vams"

module R(a, b);
  inout a, b;
  electrical a, b;
  parameter real R=5k;
  analog begin
    V(a,b) <+ R * I(a,b);
  end
endmodule
