`include "disciplines.vams"
`include "constants.vams"
module R(a, b);
  inout a, b;
  electrical a, b;
  parameter real R=5k;
  analog begin
    I(a,b) <+ (V(a,b)/R);
  end
endmodule
