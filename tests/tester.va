module test_circuit_with_external_source(a, b);
  inout a, b;
  electrical a, b, src;

  parameter real R = 5000;
  parameter real V2 = 5;
  parameter real Vext = 500;  // External source

  analog begin
    // External 500V source
    V(a,b) <+ Vext;

    // Your circuit
    V(src,b) <+ V2;
    I(a,src) <+ V(a,src)/R;
  end
endmodule
